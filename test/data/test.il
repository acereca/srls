;comment with some words

1
1.3
1e9
3.5e-4
"string"
nil
t

token
(list with items)
'(lazy list)
cstyle(list with args)

;;; precursor magnitude as controlvector
tap_mag = arg1 + arg2 - " A" / 12

;;; this
;;; is
;;; *the*
;;; valid multiline docstring
var2 = "a"
obj->op()

(let (a (b 3))
    expr1
    expr2
)

var2

(let (c d e a)
    sprintf(c)
    inner_var = "a"
    a

    (some list a)
)

(procedure prod(param1 @keys (key_param "key_param_default"))

)

tap_mag = 3

tap_mag
